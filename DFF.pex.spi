* File: DFF.pex.spi
* Created: Fri Nov 28 15:23:41 2025
* Program "Calibre xRC"
* Version "v2016.4_15.11"
*
.include "DFF.pex.spi.pex"
.subckt DFF  C D GND Q QB VDD
*
* VDD	VDD
* GND	GND
* QB	QB
* Q	Q
* D	D
* C	C
MM35 N_NET76_MM35_d N_NET88_MM35_g N_GND_MM35_s N_GND_MM35_b N_18 L=1.8e-07
+ W=4.7e-07 AD=2.303e-13 AS=2.303e-13 PD=1.45e-06 PS=1.45e-06
MM34 N_NET88_MM34_d N_C_MM34_g N_GND_MM34_s N_GND_MM35_b N_18 L=1.8e-07
+ W=4.7e-07 AD=2.303e-13 AS=2.303e-13 PD=1.45e-06 PS=1.45e-06
MM20 N_NET8_MM20_d N_NET59_MM20_g N_NET34_MM20_s N_GND_MM35_b N_18 L=1.8e-07
+ W=9.4e-07 AD=4.606e-13 AS=2.397e-13 PD=1.92e-06 PS=5.1e-07
MM16 N_NET92_MM16_d N_D_MM16_g N_NET36_MM16_s N_GND_MM35_b N_18 L=1.8e-07
+ W=9.4e-07 AD=4.606e-13 AS=2.397e-13 PD=1.92e-06 PS=5.1e-07
MM21 N_NET34_MM21_d N_NET76_MM21_g N_GND_MM21_s N_GND_MM35_b N_18 L=1.8e-07
+ W=9.4e-07 AD=2.397e-13 AS=2.397e-13 PD=5.1e-07 PS=5.1e-07
MM17 N_NET36_MM17_d N_NET88_MM17_g N_GND_MM17_s N_GND_MM35_b N_18 L=1.8e-07
+ W=9.4e-07 AD=2.397e-13 AS=2.397e-13 PD=5.1e-07 PS=5.1e-07
MM29 N_NET30_MM29_d N_NET76_MM29_g N_GND_MM29_s N_GND_MM35_b N_18 L=1.8e-07
+ W=9.4e-07 AD=2.397e-13 AS=2.397e-13 PD=5.1e-07 PS=5.1e-07
MM25 N_NET32_MM25_d N_NET88_MM25_g N_GND_MM25_s N_GND_MM35_b N_18 L=1.8e-07
+ W=9.4e-07 AD=2.397e-13 AS=2.397e-13 PD=5.1e-07 PS=5.1e-07
MM28 N_NET70_MM28_d N_NET8_MM28_g N_NET30_MM28_s N_GND_MM35_b N_18 L=1.8e-07
+ W=9.4e-07 AD=4.606e-13 AS=2.397e-13 PD=1.92e-06 PS=5.1e-07
MM24 N_NET55_MM24_d N_NET92_MM24_g N_NET32_MM24_s N_GND_MM35_b N_18 L=1.8e-07
+ W=9.4e-07 AD=4.606e-13 AS=2.397e-13 PD=1.92e-06 PS=5.1e-07
MM22 N_Q_MM22_d N_NET8_MM22_g N_NET33_MM22_s N_GND_MM35_b N_18 L=1.8e-07
+ W=9.4e-07 AD=4.606e-13 AS=2.397e-13 PD=1.92e-06 PS=5.1e-07
MM18 N_NET59_MM18_d N_NET92_MM18_g N_NET35_MM18_s N_GND_MM35_b N_18 L=1.8e-07
+ W=9.4e-07 AD=4.606e-13 AS=2.397e-13 PD=1.92e-06 PS=5.1e-07
MM23 N_NET33_MM23_d N_QB_MM23_g N_GND_MM23_s N_GND_MM35_b N_18 L=1.8e-07
+ W=9.4e-07 AD=2.397e-13 AS=2.397e-13 PD=5.1e-07 PS=5.1e-07
MM19 N_NET35_MM19_d N_NET18_MM19_g N_GND_MM19_s N_GND_MM35_b N_18 L=1.8e-07
+ W=9.4e-07 AD=2.397e-13 AS=2.397e-13 PD=5.1e-07 PS=5.1e-07
MM30 N_NET29_MM30_d N_Q_MM30_g N_GND_MM30_s N_GND_MM35_b N_18 L=1.8e-07
+ W=9.4e-07 AD=2.397e-13 AS=2.397e-13 PD=5.1e-07 PS=5.1e-07
MM26 N_NET31_MM26_d N_NET59_MM26_g N_GND_MM26_s N_GND_MM35_b N_18 L=1.8e-07
+ W=9.4e-07 AD=2.397e-13 AS=2.397e-13 PD=5.1e-07 PS=5.1e-07
MM31 N_QB_MM31_d N_NET70_MM31_g N_NET29_MM31_s N_GND_MM35_b N_18 L=1.8e-07
+ W=9.4e-07 AD=4.606e-13 AS=2.397e-13 PD=1.92e-06 PS=5.1e-07
MM27 N_NET18_MM27_d N_NET55_MM27_g N_NET31_MM27_s N_GND_MM35_b N_18 L=1.8e-07
+ W=9.4e-07 AD=4.606e-13 AS=2.397e-13 PD=1.92e-06 PS=5.1e-07
MM33 N_NET76_MM33_d N_NET88_MM33_g N_VDD_MM33_s N_VDD_MM33_b P_18 L=1.8e-07
+ W=1.41e-06 AD=6.909e-13 AS=6.909e-13 PD=2.39e-06 PS=2.39e-06
MM36 N_NET88_MM36_d N_C_MM36_g N_VDD_MM36_s N_VDD_MM33_b P_18 L=1.8e-07
+ W=1.41e-06 AD=6.909e-13 AS=6.909e-13 PD=2.39e-06 PS=2.39e-06
MM4 N_NET8_MM4_d N_NET59_MM4_g N_VDD_MM4_s N_VDD_MM33_b P_18 L=1.8e-07
+ W=1.41e-06 AD=3.5955e-13 AS=6.909e-13 PD=5.1e-07 PS=2.39e-06
MM0 N_NET92_MM0_d N_D_MM0_g N_VDD_MM0_s N_VDD_MM33_b P_18 L=1.8e-07 W=1.41e-06
+ AD=3.5955e-13 AS=6.909e-13 PD=5.1e-07 PS=2.39e-06
MM5 N_NET8_MM5_d N_NET76_MM5_g N_VDD_MM5_s N_VDD_MM33_b P_18 L=1.8e-07
+ W=1.41e-06 AD=3.5955e-13 AS=3.5955e-13 PD=5.1e-07 PS=5.1e-07
MM1 N_NET92_MM1_d N_NET88_MM1_g N_VDD_MM1_s N_VDD_MM33_b P_18 L=1.8e-07
+ W=1.41e-06 AD=3.5955e-13 AS=3.5955e-13 PD=5.1e-07 PS=5.1e-07
MM13 N_NET70_MM13_d N_NET76_MM13_g N_VDD_MM13_s N_VDD_MM33_b P_18 L=1.8e-07
+ W=1.41e-06 AD=3.5955e-13 AS=3.5955e-13 PD=5.1e-07 PS=5.1e-07
MM9 N_NET55_MM9_d N_NET88_MM9_g N_VDD_MM9_s N_VDD_MM33_b P_18 L=1.8e-07
+ W=1.41e-06 AD=3.5955e-13 AS=3.5955e-13 PD=5.1e-07 PS=5.1e-07
MM12 N_NET70_MM12_d N_NET8_MM12_g N_VDD_MM12_s N_VDD_MM33_b P_18 L=1.8e-07
+ W=1.41e-06 AD=3.5955e-13 AS=6.909e-13 PD=5.1e-07 PS=2.39e-06
MM8 N_NET55_MM8_d N_NET92_MM8_g N_VDD_MM8_s N_VDD_MM33_b P_18 L=1.8e-07
+ W=1.41e-06 AD=3.5955e-13 AS=6.909e-13 PD=5.1e-07 PS=2.39e-06
MM6 N_Q_MM6_d N_NET8_MM6_g N_VDD_MM6_s N_VDD_MM33_b P_18 L=1.8e-07 W=1.41e-06
+ AD=3.5955e-13 AS=6.909e-13 PD=5.1e-07 PS=2.39e-06
MM2 N_NET59_MM2_d N_NET92_MM2_g N_VDD_MM2_s N_VDD_MM33_b P_18 L=1.8e-07
+ W=1.41e-06 AD=3.5955e-13 AS=6.909e-13 PD=5.1e-07 PS=2.39e-06
MM7 N_Q_MM7_d N_QB_MM7_g N_VDD_MM7_s N_VDD_MM33_b P_18 L=1.8e-07 W=1.41e-06
+ AD=3.5955e-13 AS=3.5955e-13 PD=5.1e-07 PS=5.1e-07
MM3 N_NET59_MM3_d N_NET18_MM3_g N_VDD_MM3_s N_VDD_MM33_b P_18 L=1.8e-07
+ W=1.41e-06 AD=3.5955e-13 AS=3.5955e-13 PD=5.1e-07 PS=5.1e-07
MM14 N_QB_MM14_d N_Q_MM14_g N_VDD_MM14_s N_VDD_MM33_b P_18 L=1.8e-07 W=1.41e-06
+ AD=3.5955e-13 AS=3.5955e-13 PD=5.1e-07 PS=5.1e-07
MM10 N_NET18_MM10_d N_NET59_MM10_g N_VDD_MM10_s N_VDD_MM33_b P_18 L=1.8e-07
+ W=1.41e-06 AD=3.5955e-13 AS=3.5955e-13 PD=5.1e-07 PS=5.1e-07
MM15 N_QB_MM15_d N_NET70_MM15_g N_VDD_MM15_s N_VDD_MM33_b P_18 L=1.8e-07
+ W=1.41e-06 AD=3.5955e-13 AS=6.909e-13 PD=5.1e-07 PS=2.39e-06
MM11 N_NET18_MM11_d N_NET55_MM11_g N_VDD_MM11_s N_VDD_MM33_b P_18 L=1.8e-07
+ W=1.41e-06 AD=3.5955e-13 AS=6.909e-13 PD=5.1e-07 PS=2.39e-06
*
.include "DFF.pex.spi.DFF.pxi"
*
.ends
*
*
